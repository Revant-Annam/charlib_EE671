* NGSPICE file created from DFF.ext - technology: sky130A

.subckt DFXTP D CLK Q VDD VSS

X0 Q INVX4_0_a VSS VSS sky130_fd_pr__nfet_01v8 ad=0.192 pd=1.88 as=0.192 ps=2.13899 w=0.64 l=0.15
X1 VDD INVX4_0_a Q VDD sky130_fd_pr__pfet_01v8 ad=0.327 pd=2.71559 as=0.16895 ps=1.4 w=1.09 l=0.15
X2 Q INVX4_0_a VDD VDD sky130_fd_pr__pfet_01v8 ad=0.16895 pd=1.4 as=0.327 ps=2.71559 w=1.09 l=0.15
X3 INVX4_0_a INVX2_0/a VSS VSS sky130_fd_pr__nfet_01v8 ad=0.0651 pd=0.73 as=0.126 ps=1.40372 w=0.42 l=0.15
X4 VDD INVX2_0/a INVX4_0_a VDD sky130_fd_pr__pfet_01v8 ad=0.378 pd=3.13912 as=0.1953 ps=1.57 w=1.26 l=0.15
X5 INVX4_0_a INVX2_0/a VDD VDD sky130_fd_pr__pfet_01v8 ad=0.1953 pd=1.57 as=0.378 ps=3.13912 w=1.26 l=0.15
X6 VSS INVX2_0/a INVX4_0_a VSS sky130_fd_pr__nfet_01v8 ad=0.126 pd=1.40372 as=0.0651 ps=0.73 w=0.42 l=0.15
X7 INVX1_2/a TG_2/CLK INVX1_0/z VSS sky130_fd_pr__nfet_01v8 ad=0.126 pd=1.44 as=0.126 ps=1.44 w=0.42 l=0.15
X8 INVX1_2/a CLK INVX1_0/z VDD sky130_fd_pr__pfet_01v8 ad=0.378 pd=3.12 as=0.378 ps=3.12 w=1.26 l=0.15
X9 INVX1_3/z CLK INVX1_2/a VSS sky130_fd_pr__nfet_01v8 ad=0.12601 pd=1.4425 as=0.126 ps=1.44 w=0.42 l=0.15
X10 INVX1_3/z TG_2/CLK INVX1_2/a VDD sky130_fd_pr__pfet_01v8 ad=0.378 pd=3.12 as=0.378 ps=3.12 w=1.26 l=0.15
X11 INVX1_3/a CLK INVX2_0/a VSS sky130_fd_pr__nfet_01v8 ad=0.126 pd=1.44 as=0.126 ps=1.44 w=0.42 l=0.15
X12 INVX1_3/a TG_2/CLK INVX2_0/a VDD sky130_fd_pr__pfet_01v8 ad=0.378 pd=3.12 as=0.378 ps=3.12 w=1.26 l=0.15
X13 INVX2_0/a TG_2/CLK INVX1_4/z VSS sky130_fd_pr__nfet_01v8 ad=0.126 pd=1.44 as=0.126 ps=1.44 w=0.42 l=0.15
X14 INVX2_0/a CLK INVX1_4/z VDD sky130_fd_pr__pfet_01v8 ad=0.378 pd=3.12 as=0.378 ps=3.12 w=1.26 l=0.15
X15 INVX1_0/z D VSS VSS sky130_fd_pr__nfet_01v8 ad=0.126 pd=1.44 as=0.126 ps=1.40372 w=0.42 l=0.15
X16 INVX1_0/z D VDD VDD sky130_fd_pr__pfet_01v8 ad=0.378 pd=3.12 as=0.378 ps=3.13912 w=1.26 l=0.15
X17 TG_2/CLK CLK VSS VSS sky130_fd_pr__nfet_01v8 ad=0.126 pd=1.44 as=0.126 ps=1.40372 w=0.42 l=0.15
X18 TG_2/CLK CLK VDD VDD sky130_fd_pr__pfet_01v8 ad=0.378 pd=3.12 as=0.378 ps=3.13912 w=1.26 l=0.15
X19 INVX1_3/a INVX1_2/a VSS VSS sky130_fd_pr__nfet_01v8 ad=0.126 pd=1.44 as=0.126 ps=1.40372 w=0.42 l=0.15
X20 INVX1_3/a INVX1_2/a VDD VDD sky130_fd_pr__pfet_01v8 ad=0.378 pd=3.12 as=0.378 ps=3.13912 w=1.26 l=0.15
X21 INVX1_3/z INVX1_3/a VSS VSS sky130_fd_pr__nfet_01v8 ad=0.12601 pd=1.4425 as=0.126 ps=1.40372 w=0.42 l=0.15
X22 INVX1_3/z INVX1_3/a VDD VDD sky130_fd_pr__pfet_01v8 ad=0.378 pd=3.12 as=0.378 ps=3.13912 w=1.26 l=0.15
X23 INVX1_4/z INVX4_0_a VSS VSS sky130_fd_pr__nfet_01v8 ad=0.126 pd=1.44 as=0.126 ps=1.40372 w=0.42 l=0.15
X24 INVX1_4/z INVX4_0_a VDD VDD sky130_fd_pr__pfet_01v8 ad=0.378 pd=3.12 as=0.378 ps=3.13912 w=1.26 l=0.15
C0 TG_2/CLK Q 0.00121f
C1 INVX1_4/z INVX2_0/a 0.06883f
C2 INVX1_4/z Q 0.00318f
C3 INVX1_3/a VDD 1.00749f
C4 VDD INVX1_2/a 0.24129f
C5 INVX2_0/a INVX1_3/a 0.07295f
C6 INVX4_0_a VDD 0.43276f
C7 INVX1_3/a Q 0
C8 TG_2/CLK INVX1_0/z 0.06282f
C9 CLK VDD 0.84252f
C10 INVX1_3/z VDD 0.16487f
C11 D INVX1_0/z 0.03901f
C12 INVX4_0_a INVX2_0/a 0.14272f
C13 INVX4_0_a Q 0.08972f
C14 CLK INVX2_0/a 0.15677f
C15 CLK Q 0
C16 INVX1_0/z INVX1_3/a 0.03467f
C17 TG_2/CLK INVX1_4/z 0.01396f
C18 TG_2/CLK D 0.03906f
C19 INVX1_0/z INVX1_2/a 0.06951f
C20 INVX4_0_a INVX1_0/z 0
C21 TG_2/CLK INVX1_3/a 0.12792f
C22 CLK INVX1_0/z 0.06853f
C23 INVX1_4/z INVX1_3/a 0
C24 INVX1_0/z INVX1_3/z 0
C25 D INVX1_3/a 0.00429f
C26 TG_2/CLK INVX1_2/a 0.19165f
C27 TG_2/CLK INVX4_0_a 0.09566f
C28 D INVX1_2/a 0.00436f
C29 INVX1_4/z INVX4_0_a 0.10395f
C30 TG_2/CLK CLK 0.54765f
C31 D INVX4_0_a 0
C32 TG_2/CLK INVX1_3/z 0.10754f
C33 INVX1_4/z CLK 0.01644f
C34 D CLK 0.0269f
C35 INVX2_0/a VDD 0.35082f
C36 INVX1_3/a INVX1_2/a 0.10475f
C37 VDD Q 0.12274f
C38 D INVX1_3/z 0
C39 INVX4_0_a INVX1_3/a 0
C40 CLK INVX1_3/a 0.39658f
C41 INVX4_0_a INVX1_2/a 0
C42 INVX1_3/a INVX1_3/z 0.13639f
C43 CLK INVX1_2/a 0.16273f
C44 INVX1_0/z VDD 0.1885f
C45 INVX1_3/z INVX1_2/a 0.07089f
C46 INVX4_0_a CLK 0.08871f
C47 CLK INVX1_3/z 0.11234f
C48 TG_2/CLK VDD 0.6207f
C49 INVX1_4/z VDD 0.20451f
C50 D VDD 0.08539f
C51 TG_2/CLK INVX2_0/a 0.09632f
C52 INVX1_2/a VSS 0.24905f
C53 INVX1_4/z VSS 0.12363f
C54 INVX4_0_a VSS 0.66417f
C55 INVX1_0/z VSS 0.11107f
C56 D VSS 0.13637f
C57 TG_2/CLK VSS 1.53383f
C58 INVX2_0/a VSS 0.39165f
C59 CLK VSS 1.07356f
C60 INVX1_3/a VSS 0.27619f
C61 INVX1_3/z VSS 0.31123f
C62 Q VSS 0.12733f
C63 VDD VSS 5.11458f

.ends DFXTP
